ADE simulation setup
Run mode: Single Run, Sweeps and Corners
Tests:
  ctrl-test (off): project-02/alu/schematic, simulator spectre
  0-add: project-02/alu/av_extracted, simulator spectre
  1-sub: project-02/alu/av_extracted, simulator spectre
  2-mul: project-02/alu/av_extracted, simulator spectre
  3-div: project-02/alu/av_extracted, simulator spectre
  4-rsh: project-02/alu/av_extracted, simulator spectre
  5-lsh: project-02/alu/av_extracted, simulator spectre
  6-bor: project-02/alu/av_extracted, simulator spectre
  7-band: project-02/alu/av_extracted, simulator spectre
