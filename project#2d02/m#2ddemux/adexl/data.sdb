ADE simulation setup
Run mode: Single Run, Sweeps and Corners
Tests:
  extract: project-02/m-demux/av_extracted, simulator spectre
  project-02:m-demux:1: project-02/m-demux/schematic, simulator spectre
