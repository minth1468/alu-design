ADE simulation setup
Run mode: Single Run, Sweeps and Corners
Tests:
  project-02:m-demux:1: project-02/m-demux/schematic, simulator spectre
