ADE simulation setup
Run mode: Single Run, Sweeps and Corners
Tests:
  project-02:op-div:1: project-02/op-div/schematic, simulator spectre
