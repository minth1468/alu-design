ADE simulation setup
Run mode: Single Run, Sweeps and Corners
Tests:
  project-02:op-bor:1: project-02/op-bor/schematic, simulator spectre
