ADE simulation setup
Run mode: Single Run, Sweeps and Corners
Tests:
  project-01-static-cmos:nand:1: project-01-static-cmos/nand/schematic, simulator spectre
  extracted: project-01-static-cmos/nand/av_extracted, simulator spectre
