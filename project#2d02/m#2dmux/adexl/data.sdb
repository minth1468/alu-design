ADE simulation setup
Run mode: Single Run, Sweeps and Corners
Tests:
  project-02:m-mux:1: project-02/m-mux/schematic, simulator spectre
