ADE simulation setup
Run mode: Single Run, Sweeps and Corners
Tests:
  project-02:op-band:1: project-02/op-band/schematic, simulator spectre
